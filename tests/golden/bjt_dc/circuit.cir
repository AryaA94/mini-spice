* Golden regression fixture: NPN fixed-bias DC operating point
VBB base 0 DC 5
RB base b1 100k
VCC vcc 0 DC 10
RC vcc col 1k
Q1 col b1 0 IS=1e-16 BF=100 BR=1
