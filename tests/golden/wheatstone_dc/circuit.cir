* Golden regression fixture: balanced Wheatstone bridge
V1 top 0 DC 9
R1 top a 1k
R2 a 0 2k
R3 top b 2k
R4 b 0 4k
Rg a b 500
