* Golden regression fixture: DC voltage divider
V1 in 0 DC 10
R1 in out 1k
R2 out 0 1k
