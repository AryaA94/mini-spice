* Golden regression fixture: RC low-pass AC sweep
V1 in 0 DC 0 AC 1 0
R1 in out 1k
C1 out 0 100n
