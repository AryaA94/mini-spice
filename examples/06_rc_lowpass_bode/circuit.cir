* RC low-pass filter, AC small-signal sweep. Corner frequency
* f_c = 1/(2*pi*R*C) = 1/(2*pi*1k*100n) = 1591.5 Hz.
V1 in 0 DC 0 AC 1 0
R1 in out 1k
C1 out 0 100n
