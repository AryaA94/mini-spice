* PNP fixed-bias circuit -- the exact mirror of examples/09_bjt_fixed_bias
* (every supply negated, TYPE=PNP): V(b1) and V(col) should come out as
* the exact negation of that circuit's NPN results.
VBB base 0 DC -5
RB base b1 100k
VCC vcc 0 DC -10
RC vcc col 1k
Q1 col b1 0 IS=1e-16 BF=100 BR=1 TYPE=PNP
