* Same RC circuit as 03_rc_step, re-run at several step sizes to check
* starting at its default initial condition (0V) rather than a switching
* source -- the standard way to pose this experiment in simulation.
* tau = R*C = 1k * 1u = 1ms
V1 in 0 DC 5
R1 in out 1k
C1 out 0 1u
